* Full Adder 18T - Post-layout Delay Cin

.lib /foss/pdks/sky130A/libs.tech/ngspice/sky130.lib.spice tt
.include ../pex/Full_adder_1bit_pex.spice

.temp 27

VPOWER VDD 0 1.8

* Toggle Cin, hold A=0 and B=1
VA A 0 0
VB B 0 1.8
VC Cin 0 PULSE(0 1.8 5n 100p 100p 20n 40n)

XFA 0 VDD A B Abar PbarX PbarM Cin Sum Cout P Full_adder_1bit

CLSUM Sum 0 10f
CLCOUT Cout 0 10f

.tran 5p 40n 0 5p

.meas tran tPHL_SUM TRIG v(Cin) VAL=0.9 RISE=1
+ TARG v(Sum) VAL=0.9 FALL=1

.meas tran tPLH_SUM TRIG v(Cin) VAL=0.9 FALL=1
+ TARG v(Sum) VAL=0.9 RISE=1

.meas tran tPLH_COUT TRIG v(Cin) VAL=0.9 RISE=1
+ TARG v(Cout) VAL=0.9 RISE=1

.meas tran tPHL_COUT TRIG v(Cin) VAL=0.9 FALL=1
+ TARG v(Cout) VAL=0.9 FALL=1

.meas tran tPD_SUM PARAM='(tPLH_SUM+tPHL_SUM)/2'
.meas tran tPD_COUT PARAM='(tPLH_COUT+tPHL_COUT)/2'

.control
run
write fa_post_delay_Cin.raw
plot v(A)+8 v(B)+6 v(Cin)+4 v(Sum)+2 v(Cout)
.endc

.end
