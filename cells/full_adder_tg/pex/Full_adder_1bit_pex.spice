* NGSPICE file created from Full_adder_1bit.ext - technology: sky130A

.subckt Full_adder_1bit GND VDD A B Abar PbarX PbarM Cin Sum Cout P
X0 B.t3 PbarM.t2 Cout.t3 GND.t7 sky130_fd_pr__nfet_01v8 ad=1.38 pd=5.38 as=0.82 ps=2.82 w=2 l=0.15
X1 Cout.t0 P.t5 Cin.t0 GND.t5 sky130_fd_pr__nfet_01v8 ad=0.82 pd=2.82 as=1.38 ps=5.38 w=2 l=0.15
X2 Abar.t2 A.t3 VDD.t10 VDD.t9 sky130_fd_pr__pfet_01v8 ad=3.375 pd=11.35 as=3.375 ps=11.35 w=5 l=0.15
X3 B.t1 Abar.t3 P.t4 GND.t6 sky130_fd_pr__nfet_01v8 ad=1.38 pd=5.38 as=0.82 ps=2.82 w=2 l=0.15
X4 B.t2 A.t2 P.t3 VDD.t11 sky130_fd_pr__pfet_01v8 ad=3.45 pd=11.38 as=2.05 ps=5.82 w=5 l=0.15
X5 Cin.t1 P.t10 Sum.t1 VDD.t3 sky130_fd_pr__pfet_01v8 ad=3.45 pd=11.38 as=2.05 ps=5.82 w=5 l=0.15
X6 P.t1 B.t4 Abar.t0 GND.t9 sky130_fd_pr__nfet_01v8 ad=0.82 pd=2.82 as=1.38 ps=5.38 w=2 l=0.15
X7 P.t2 B.t5 A.t0 VDD.t8 sky130_fd_pr__pfet_01v8 ad=2.05 pd=5.82 as=3.45 ps=11.38 w=5 l=0.15
X8 Sum.t3 Cin.t5 P.t0 VDD.t0 sky130_fd_pr__pfet_01v8 ad=2.05 pd=5.82 as=3.45 ps=11.38 w=5 l=0.15
X9 B.t0 P.t8 Cout.t2 VDD.t6 sky130_fd_pr__pfet_01v8 ad=3.45 pd=11.38 as=2.05 ps=5.82 w=5 l=0.15
X10 PbarX.t1 P.t11 VDD.t2 VDD.t1 sky130_fd_pr__pfet_01v8 ad=3.375 pd=11.35 as=3.375 ps=11.35 w=5 l=0.15
X11 PbarX.t0 P.t7 GND.t4 GND.t3 sky130_fd_pr__nfet_01v8 ad=1.35 pd=5.35 as=1.35 ps=5.35 w=2 l=0.15
X12 Cout.t1 PbarM.t3 Cin.t2 VDD.t7 sky130_fd_pr__pfet_01v8 ad=2.05 pd=5.82 as=3.45 ps=11.38 w=5 l=0.15
X13 Abar.t1 A.t1 GND.t11 GND.t10 sky130_fd_pr__nfet_01v8 ad=1.35 pd=5.35 as=1.35 ps=5.35 w=2 l=0.15
X14 Cin.t3 PbarX.t3 Sum.t0 GND.t8 sky130_fd_pr__nfet_01v8 ad=1.38 pd=5.38 as=0.82 ps=2.82 w=2 l=0.15
X15 PbarM.t0 P.t9 VDD.t5 VDD.t4 sky130_fd_pr__pfet_01v8 ad=3.375 pd=11.35 as=3.375 ps=11.35 w=5 l=0.15
X16 PbarM.t1 P.t6 GND.t2 GND.t1 sky130_fd_pr__nfet_01v8 ad=1.35 pd=5.35 as=1.35 ps=5.35 w=2 l=0.15
X17 Sum.t2 Cin.t4 PbarX.t2 GND.t0 sky130_fd_pr__nfet_01v8 ad=0.82 pd=2.82 as=1.38 ps=5.38 w=2 l=0.15
R0 Cout.n2 Cout.n0 89.0349
R1 Cout.n2 Cout.n1 65.9958
R2 Cout.n1 Cout.t3 24.6005
R3 Cout.n1 Cout.t0 24.6005
R4 Cout.n0 Cout.t2 16.1545
R5 Cout.n0 Cout.t1 16.1545
R6 Cout Cout.n2 11.3357
R7 PbarM.n0 PbarM.t3 1147
R8 PbarM.n0 PbarM.t2 615.926
R9 PbarM.n1 PbarM.t0 104.939
R10 PbarM.n1 PbarM.t1 90.8458
R11 PbarM PbarM.n2 5.96073
R12 PbarM.n2 PbarM.n1 4.5005
R13 PbarM.n2 PbarM.n0 0.691788
R14 Sum.n2 Sum.n0 88.5349
R15 Sum.n2 Sum.n1 66.4958
R16 Sum.n1 Sum.t0 24.6005
R17 Sum.n1 Sum.t2 24.6005
R18 Sum.n0 Sum.t1 16.1545
R19 Sum.n0 Sum.t3 16.1545
R20 Sum Sum.n2 8.83762
R21 PbarX.n0 PbarX.t3 616.856
R22 PbarX.n1 PbarX.t1 104.189
R23 PbarX.n0 PbarX.t2 96.0968
R24 PbarX.n1 PbarX.t0 91.5958
R25 PbarX.n2 PbarX.n1 4.5005
R26 PbarX PbarX.n2 3.46262
R27 PbarX.n2 PbarX.n0 0.511864
R28 Cin.n3 Cin.t5 1142
R29 Cin.n3 Cin.t4 611.557
R30 Cin.n1 Cin.t1 104.439
R31 Cin.n0 Cin.t2 104.439
R32 Cin.n0 Cin.t0 91.3458
R33 Cin.n1 Cin.t3 91.3458
R34 Cin.n2 Cin.n0 6.26565
R35 Cin.n2 Cin.n1 4.5005
R36 Cin.n4 Cin.n3 4.5005
R37 Cin Cin.n4 4.15391
R38 Cin.n4 Cin.n2 0.55353
R39 P.n0 P.t8 1146.73
R40 P.n3 P.t10 1146
R41 P.n1 P.t9 1139.89
R42 P.n5 P.t11 1139.89
R43 P.n0 P.t5 625.918
R44 P.n1 P.t6 612.057
R45 P.n5 P.t7 612.057
R46 P.n4 P.t0 108.439
R47 P.n9 P.n7 87.7849
R48 P.n9 P.n8 67.2458
R49 P.n8 P.t1 24.6005
R50 P.n8 P.t4 24.6005
R51 P.n7 P.t2 16.1545
R52 P.n7 P.t3 16.1545
R53 P.n10 P.n9 4.5005
R54 P.n6 P.n5 4.5005
R55 P.n2 P.n1 4.5005
R56 P P.n10 1.85845
R57 P.n10 P.n6 1.43989
R58 P.n3 P.n2 1.25618
R59 P.n6 P.n4 0.693682
R60 P.n4 P.n3 0.551636
R61 P.n2 P.n0 0.513758
R62 Abar.n0 Abar.t3 617.36
R63 Abar.n1 Abar.t2 103.689
R64 Abar.n0 Abar.t0 96.5968
R65 Abar.n1 Abar.t1 92.0958
R66 Abar.n2 Abar.n1 4.5005
R67 Abar Abar.n2 0.968303
R68 Abar.n2 Abar.n0 0.508076
R69 B.n3 B.t5 1141
R70 B.n3 B.t4 612.557
R71 B.n1 B.t2 103.439
R72 B.n0 B.t0 103.439
R73 B.n0 B.t3 92.3458
R74 B.n1 B.t1 92.3458
R75 B.n2 B.n0 9.5005
R76 B.n2 B.n1 4.5005
R77 B.n4 B.n3 4.5005
R78 B B.n4 1.65012
R79 B.n4 B.n2 0.55353
R80 A.n0 A.t2 1145.8
R81 A.n1 A.t3 1138.07
R82 A.n1 A.t1 612.807
R83 A.n0 A.t0 107.691
R84 A.n2 A.n1 4.5005
R85 A A.n2 0.790273
R86 A.n2 A.n0 0.693682
R87 VDD.t11 VDD.t1 383.354
R88 VDD.t3 VDD.t4 383.354
R89 VDD VDD.n2 380.18
R90 VDD.n3 VDD.n1 380.13
R91 VDD.n4 VDD.n0 380.13
R92 VDD.n2 VDD.t8 219.72
R93 VDD.n1 VDD.t0 219.72
R94 VDD.n0 VDD.t7 219.72
R95 VDD.t8 VDD.t11 112.174
R96 VDD.t0 VDD.t3 112.174
R97 VDD.t7 VDD.t6 112.174
R98 VDD.n5 VDD.t5 107.439
R99 VDD.n6 VDD.t2 107.439
R100 VDD.n7 VDD.t10 107.439
R101 VDD.n2 VDD.t9 47.992
R102 VDD.t1 VDD.n1 47.992
R103 VDD.t4 VDD.n0 47.992
R104 VDD.n5 VDD.n4 11.5247
R105 VDD.n7 VDD.n6 2.5005
R106 VDD.n6 VDD.n5 2.5005
R107 VDD.n4 VDD.n3 1.03175
R108 VDD.n3 VDD 0.982531
R109 VDD VDD.n7 0.610348
R110 GND.t10 GND.t7 118388
R111 GND GND.n0 1179.71
R112 GND.n2 GND.t1 1179.65
R113 GND.n1 GND.t3 1179.65
R114 GND.t6 GND.t3 933.333
R115 GND.t8 GND.t1 930.527
R116 GND.t3 GND.t0 649.826
R117 GND.t5 GND.t1 649.826
R118 GND.n0 GND.t9 634.386
R119 GND.t9 GND.t6 272.281
R120 GND.t0 GND.t8 272.281
R121 GND.t7 GND.t5 272.281
R122 GND.n3 GND.t2 94.8468
R123 GND.n4 GND.t4 94.8468
R124 GND.n5 GND.t11 94.8466
R125 GND.n0 GND.t10 15.4391
R126 GND.n3 GND.n2 10.0782
R127 GND.n5 GND.n4 2.50429
R128 GND.n4 GND.n3 2.5005
R129 GND.n2 GND.n1 1.03175
R130 GND.n1 GND 0.96925
R131 GND GND.n5 0.583833
C0 PbarM VDD 0.68759f
C1 Abar PbarX 0.19682f
C2 P B 1.80049f
C3 B VDD 0.93341f
C4 PbarM Cin 0.98768f
C5 Sum Cout 0.09272f
C6 A Cout 0.09607f
C7 Cin B 0.30302f
C8 P Abar 1.74543f
C9 Abar VDD 0.4389f
C10 Sum A 0.09604f
C11 P PbarX 1.96854f
C12 PbarM Cout 1.61869f
C13 PbarX VDD 0.43788f
C14 Abar Cin 0.29296f
C15 B Cout 0.58855f
C16 Sum PbarM 0.9767f
C17 PbarM A 0.14728f
C18 PbarX Cin 1.73864f
C19 Sum B 0.19858f
C20 P VDD 1.69452f
C21 B A 1.50489f
C22 Abar Cout 0.18849f
C23 P Cin 1.47412f
C24 PbarX Cout 0.1951f
C25 PbarM B 0.4261f
C26 Sum Abar 0.1885f
C27 Cin VDD 0.8181f
C28 Abar A 0.93729f
C29 Sum PbarX 0.59071f
C30 PbarX A 0.10429f
C31 P Cout 0.65128f
C32 Abar PbarM 0.23968f
C33 VDD Cout 0.10302f
C34 Abar B 1.8149f
C35 PbarX PbarM 0.23767f
C36 Sum P 0.79208f
C37 P A 0.78751f
C38 Cin Cout 0.57391f
C39 Sum VDD 0.09912f
C40 PbarX B 0.20683f
C41 VDD A 1.74398f
C42 Sum Cin 1.98605f
C43 P PbarM 1.11845f
C44 Cin A 0.20051f
C45 Cout GND 2.25508f
C46 PbarM GND 1.78101f
C47 Sum GND 1.56402f
C48 PbarX GND 1.6034f
C49 Cin GND 1.89055f
C50 P GND 2.79385f
C51 Abar GND 1.41267f
C52 B GND 2.10862f
C53 A GND 1.22854f
C54 VDD GND 22.23332f
C55 GND.t2 GND 0.04988f
C56 GND.t4 GND 0.04988f
C57 GND.t11 GND 0.05124f
C58 VDD.t6 GND 0.51948f
C59 VDD.t7 GND 0.39235f
C60 VDD.n0 GND 0.32244f
C61 VDD.t4 GND 0.50991f
C62 VDD.t3 GND 0.58579f
C63 VDD.t0 GND 0.39235f
C64 VDD.n1 GND 0.32244f
C65 VDD.t1 GND 0.50991f
C66 VDD.t11 GND 0.58579f
C67 VDD.t8 GND 0.39235f
C68 VDD.t9 GND 0.43951f
C69 VDD.n2 GND 0.32245f
C70 VDD.n3 GND 0.2085f
C71 VDD.n4 GND 0.36095f
C72 VDD.t5 GND 0.19888f
C73 VDD.n5 GND 0.24693f
C74 VDD.t2 GND 0.19888f
C75 VDD.n6 GND 0.18718f
C76 VDD.t10 GND 0.20137f
C77 VDD.n7 GND 0.15978f
C78 A.t0 GND 0.94437f
C79 A.n0 GND 2.90438f
C80 A.n1 GND 1.09115f
C81 A.n2 GND 0.17009f
C82 B.t0 GND 0.77304f
C83 B.t3 GND 0.31328f
C84 B.n0 GND 1.94723f
C85 B.t2 GND 0.77453f
C86 B.t1 GND 0.30823f
C87 B.n1 GND 1.62752f
C88 B.n2 GND 0.81067f
C89 B.n3 GND 0.89625f
C90 B.n4 GND 0.20742f
C91 Abar.t0 GND 0.35561f
C92 Abar.n0 GND 2.6485f
C93 Abar.t2 GND 0.81019f
C94 Abar.t1 GND 0.32311f
C95 Abar.n1 GND 1.73851f
C96 Abar.n2 GND 0.14881f
C97 P.n0 GND 1.65979f
C98 P.n1 GND 1.07096f
C99 P.n2 GND 0.19902f
C100 P.n3 GND 0.74455f
C101 P.t0 GND 0.94798f
C102 P.n4 GND 1.23951f
C103 P.n5 GND 1.07096f
C104 P.n6 GND 0.23993f
C105 P.t3 GND 0.35941f
C106 P.t2 GND 0.34153f
C107 P.n7 GND 0.55757f
C108 P.t4 GND 0.15352f
C109 P.t1 GND 0.14785f
C110 P.n8 GND 0.23547f
C111 P.n9 GND 1.76879f
C112 P.n10 GND 0.37098f
C113 Cin.t2 GND 0.83889f
C114 Cin.t0 GND 0.32703f
C115 Cin.n0 GND 1.88469f
C116 Cin.t1 GND 0.83493f
C117 Cin.t3 GND 0.31832f
C118 Cin.n1 GND 1.75092f
C119 Cin.n2 GND 0.57615f
C120 Cin.n3 GND 0.96562f
C121 Cin.n4 GND 0.47731f
C122 PbarX.t2 GND 0.34151f
C123 PbarX.n0 GND 1.89691f
C124 PbarX.t1 GND 0.79221f
C125 PbarX.t0 GND 0.31024f
C126 PbarX.n1 GND 1.68848f
C127 PbarX.n2 GND 0.38945f
C128 Sum.t1 GND 0.35335f
C129 Sum.t3 GND 0.34334f
C130 Sum.n0 GND 0.55778f
C131 Sum.t0 GND 0.14978f
C132 Sum.t2 GND 0.14896f
C133 Sum.n1 GND 0.22439f
C134 Sum.n2 GND 2.3638f
C135 PbarM.n0 GND 1.50955f
C136 PbarM.t0 GND 0.93301f
C137 PbarM.t1 GND 0.35338f
C138 PbarM.n1 GND 2.00172f
C139 PbarM.n2 GND 0.77428f
C140 Cout.t2 GND 0.30627f
C141 Cout.t1 GND 0.30997f
C142 Cout.n0 GND 0.46202f
C143 Cout.t3 GND 0.13791f
C144 Cout.t0 GND 0.13955f
C145 Cout.n1 GND 0.18044f
C146 Cout.n2 GND 1.9121f
.ends
