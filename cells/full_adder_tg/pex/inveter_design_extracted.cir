* Extracted by KLayout with SKY130 LVS runset on : 28/11/2026 05:40

.SUBCKT inveter_design
M$1 \$13 \$9 \$10 \$14 sky130_fd_pr__pfet_01v8 L=0.15 W=5 AS=3.45 AD=2.05
+ PS=11.38 PD=5.82
M$2 \$10 \$6 \$12 \$14 sky130_fd_pr__pfet_01v8 L=0.15 W=5 AS=2.05 AD=3.45
+ PS=5.82 PD=11.38
M$3 \$14 \$6 \$7 \$14 sky130_fd_pr__pfet_01v8 L=0.15 W=5 AS=3.375 AD=3.375
+ PS=11.35 PD=11.35
M$4 \$11 \$12 \$6 \$14 sky130_fd_pr__pfet_01v8 L=0.15 W=5 AS=3.45 AD=2.05
+ PS=11.38 PD=5.82
M$5 \$6 \$11 \$12 \$14 sky130_fd_pr__pfet_01v8 L=0.15 W=5 AS=2.05 AD=3.45
+ PS=5.82 PD=11.38
M$6 \$6 \$13 \$8 \$14 sky130_fd_pr__pfet_01v8 L=0.15 W=5 AS=3.45 AD=2.05
+ PS=11.38 PD=5.82
M$7 \$8 \$6 \$13 \$14 sky130_fd_pr__pfet_01v8 L=0.15 W=5 AS=2.05 AD=3.45
+ PS=5.82 PD=11.38
M$8 \$14 \$11 \$5 \$14 sky130_fd_pr__pfet_01v8 L=0.15 W=5 AS=3.375 AD=3.375
+ PS=11.35 PD=11.35
M$9 \$14 \$6 \$9 \$14 sky130_fd_pr__pfet_01v8 L=0.15 W=5 AS=3.375 AD=3.375
+ PS=11.35 PD=11.35
M$10 \$7 \$13 \$8 sky130_gnd sky130_fd_pr__nfet_01v8 L=0.15 W=2 AS=1.38 AD=0.82
+ PS=5.38 PD=2.82
M$11 \$8 \$7 \$13 sky130_gnd sky130_fd_pr__nfet_01v8 L=0.15 W=2 AS=0.82 AD=1.38
+ PS=2.82 PD=5.38
M$12 sky130_gnd \$6 \$9 sky130_gnd sky130_fd_pr__nfet_01v8 L=0.15 W=2 AS=1.35
+ AD=1.35 PS=5.35 PD=5.35
M$13 sky130_gnd \$6 \$7 sky130_gnd sky130_fd_pr__nfet_01v8 L=0.15 W=2 AS=1.35
+ AD=1.35 PS=5.35 PD=5.35
M$14 \$5 \$12 \$6 sky130_gnd sky130_fd_pr__nfet_01v8 L=0.15 W=2 AS=1.38 AD=0.82
+ PS=5.38 PD=2.82
M$15 \$6 \$5 \$12 sky130_gnd sky130_fd_pr__nfet_01v8 L=0.15 W=2 AS=0.82 AD=1.38
+ PS=2.82 PD=5.38
M$16 \$13 \$6 \$10 sky130_gnd sky130_fd_pr__nfet_01v8 L=0.15 W=2 AS=1.38
+ AD=0.82 PS=5.38 PD=2.82
M$17 \$10 \$9 \$12 sky130_gnd sky130_fd_pr__nfet_01v8 L=0.15 W=2 AS=0.82
+ AD=1.38 PS=2.82 PD=5.38
M$18 sky130_gnd \$11 \$5 sky130_gnd sky130_fd_pr__nfet_01v8 L=0.15 W=2 AS=1.35
+ AD=1.35 PS=5.35 PD=5.35
.ENDS inveter_design
