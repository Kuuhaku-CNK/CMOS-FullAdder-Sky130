* NGSPICE file created from Full_adder_1bit.ext - technology: sky130A

.subckt Full_adder_1bit GND VDD A B A' P'_X P'_M Cin Sum Cout P
X0 B P'_M Cout GND.t9 sky130_fd_pr__nfet_01v8 ad=1.38 pd=5.38 as=0.82 ps=2.82 w=2 l=0.15
X1 Cout P Cin GND.t5 sky130_fd_pr__nfet_01v8 ad=0.82 pd=2.82 as=1.38 ps=5.38 w=2 l=0.15
X2 A' A VDD.t10 VDD.t9 sky130_fd_pr__pfet_01v8 ad=3.375 pd=11.35 as=3.375 ps=11.35 w=5 l=0.15
X3 B A' P GND.t8 sky130_fd_pr__nfet_01v8 ad=1.38 pd=5.38 as=0.82 ps=2.82 w=2 l=0.15
X4 B A P VDD.t11 sky130_fd_pr__pfet_01v8 ad=3.45 pd=11.38 as=2.05 ps=5.82 w=5 l=0.15
X5 Cin P Sum VDD.t3 sky130_fd_pr__pfet_01v8 ad=3.45 pd=11.38 as=2.05 ps=5.82 w=5 l=0.15
X6 P B A' GND.t0 sky130_fd_pr__nfet_01v8 ad=0.82 pd=2.82 as=1.38 ps=5.38 w=2 l=0.15
X7 P B A VDD.t0 sky130_fd_pr__pfet_01v8 ad=2.05 pd=5.82 as=3.45 ps=11.38 w=5 l=0.15
X8 Sum Cin P VDD.t7 sky130_fd_pr__pfet_01v8 ad=2.05 pd=5.82 as=3.45 ps=11.38 w=5 l=0.15
X9 B P Cout VDD.t6 sky130_fd_pr__pfet_01v8 ad=3.45 pd=11.38 as=2.05 ps=5.82 w=5 l=0.15
X10 P'_X P VDD.t2 VDD.t1 sky130_fd_pr__pfet_01v8 ad=3.375 pd=11.35 as=3.375 ps=11.35 w=5 l=0.15
X11 P'_X P GND.t2 GND.t1 sky130_fd_pr__nfet_01v8 ad=1.35 pd=5.35 as=1.35 ps=5.35 w=2 l=0.15
X12 Cout P'_M Cin VDD.t8 sky130_fd_pr__pfet_01v8 ad=2.05 pd=5.82 as=3.45 ps=11.38 w=5 l=0.15
X13 A' A GND.t11 GND.t10 sky130_fd_pr__nfet_01v8 ad=1.35 pd=5.35 as=1.35 ps=5.35 w=2 l=0.15
X14 Cin P'_X Sum GND.t6 sky130_fd_pr__nfet_01v8 ad=1.38 pd=5.38 as=0.82 ps=2.82 w=2 l=0.15
X15 P'_M P VDD.t5 VDD.t4 sky130_fd_pr__pfet_01v8 ad=3.375 pd=11.35 as=3.375 ps=11.35 w=5 l=0.15
X16 P'_M P GND.t4 GND.t3 sky130_fd_pr__nfet_01v8 ad=1.35 pd=5.35 as=1.35 ps=5.35 w=2 l=0.15
X17 Sum Cin P'_X GND.t7 sky130_fd_pr__nfet_01v8 ad=0.82 pd=2.82 as=1.38 ps=5.38 w=2 l=0.15
R0 VDD.t11 VDD.t1 383.354
R1 VDD.t3 VDD.t4 383.354
R2 VDD VDD.n2 380.18
R3 VDD VDD.n1 380.13
R4 VDD.n3 VDD.n0 380.13
R5 VDD.n2 VDD.t0 219.72
R6 VDD.n1 VDD.t7 219.72
R7 VDD.n0 VDD.t8 219.72
R8 VDD.t0 VDD.t11 112.174
R9 VDD.t7 VDD.t3 112.174
R10 VDD.t8 VDD.t6 112.174
R11 VDD.n4 VDD.t5 107.439
R12 VDD.n5 VDD.t2 107.439
R13 VDD VDD.t10 107.439
R14 VDD.n2 VDD.t9 47.992
R15 VDD.t1 VDD.n1 47.992
R16 VDD.t4 VDD.n0 47.992
R17 VDD.n4 VDD.n3 11.5247
R18 VDD.n5 VDD.n4 2.5005
R19 VDD VDD.n5 2.5005
R20 VDD.n3 VDD 2.01378
R21 GND.t10 GND.t9 118388
R22 GND GND.n0 1179.71
R23 GND.n1 GND.t3 1179.65
R24 GND GND.t1 1179.65
R25 GND.t8 GND.t1 933.333
R26 GND.t6 GND.t3 930.527
R27 GND.t1 GND.t7 649.826
R28 GND.t5 GND.t3 649.826
R29 GND.n0 GND.t0 634.386
R30 GND.t0 GND.t8 272.281
R31 GND.t7 GND.t6 272.281
R32 GND.t9 GND.t5 272.281
R33 GND.n2 GND.t4 94.8468
R34 GND.n3 GND.t2 94.8468
R35 GND GND.t11 94.8466
R36 GND.n0 GND.t10 15.4391
R37 GND.n2 GND.n1 10.0782
R38 GND GND.n3 2.50429
R39 GND.n3 GND.n2 2.5005
R40 GND.n1 GND 2.0005
C0 Sum A 0.09604f
C1 Cin A' 0.29296f
C2 P'_M VDD 0.68759f
C3 Sum A' 0.1885f
C4 P'_X B 0.20683f
C5 P VDD 1.69452f
C6 A B 1.50489f
C7 Cin Cout 0.57391f
C8 A' B 1.8149f
C9 Cout Sum 0.09272f
C10 Cin P'_M 0.98768f
C11 P'_X A 0.10429f
C12 Cout B 0.58855f
C13 P'_M Sum 0.9767f
C14 Cin P 1.47412f
C15 P'_X A' 0.19682f
C16 P Sum 0.79208f
C17 A' A 0.93729f
C18 P'_M B 0.4261f
C19 Cin VDD 0.8181f
C20 P B 1.80049f
C21 Sum VDD 0.09912f
C22 P'_X Cout 0.1951f
C23 Cout A 0.09607f
C24 B VDD 0.93341f
C25 Cout A' 0.18849f
C26 P'_X P'_M 0.23767f
C27 P'_X P 1.96854f
C28 P'_M A 0.14728f
C29 Cin Sum 1.98605f
C30 P A 0.78751f
C31 P'_M A' 0.23968f
C32 P A' 1.74543f
C33 P'_X VDD 0.43788f
C34 Cin B 0.30302f
C35 A VDD 1.74398f
C36 P'_M Cout 1.61869f
C37 Sum B 0.19858f
C38 A' VDD 0.4389f
C39 P Cout 0.65128f
C40 P'_X Cin 1.73864f
C41 Cout VDD 0.10302f
C42 P P'_M 1.11845f
C43 P'_X Sum 0.59071f
C44 Cin A 0.20051f
C45 Cout GND 4.77397f
C46 Sum GND 3.42644f
C47 P'_X GND 0.31258f
C48 A' GND 1.70338f
C49 B GND 1.65365f
C50 VDD GND 22.60159f
C51 VDD.t6 GND 0.51948f
C52 VDD.t8 GND 0.39235f
C53 VDD.n0 GND 0.32244f
C54 VDD.t4 GND 0.50991f
C55 VDD.t3 GND 0.58579f
C56 VDD.t7 GND 0.39235f
C57 VDD.n1 GND 0.32244f
C58 VDD.t1 GND 0.50991f
C59 VDD.t11 GND 0.58579f
C60 VDD.t0 GND 0.39235f
C61 VDD.t9 GND 0.43951f
C62 VDD.n2 GND 0.32245f
C63 VDD.n3 GND 0.36095f
C64 VDD.t5 GND 0.10697f
C65 VDD.n4 GND 0.24693f
C66 VDD.t2 GND 0.10697f
C67 VDD.n5 GND 0.18718f
C68 VDD.t10 GND 0.66921f
.ends
