* NGSPICE file created from Full_adder_1bit.ext - technology: sky130A

.subckt Full_adder_1bit 0 VDD A B A' P'_X P'_M Cin Sum Cout P
X0 B.t3 P'_M.t2 Cout.t2 error sky130_fd_pr__nfet_01v8 ad=1.38 pd=5.38 as=0.82 ps=2.82 w=2 l=0.15
X1 Cout.t3 P.t5 Cin.t1 error sky130_fd_pr__nfet_01v8 ad=0.82 pd=2.82 as=1.38 ps=5.38 w=2 l=0.15
X2 A'.t0 A.t3 VDD.t2 VDD.t1 sky130_fd_pr__pfet_01v8 ad=3.375 pd=11.35 as=3.375 ps=11.35 w=5 l=0.15
X3 B.t1 A'.t3 P.t2 error sky130_fd_pr__nfet_01v8 ad=1.38 pd=5.38 as=0.82 ps=2.82 w=2 l=0.15
X4 B.t0 A.t2 P.t0 VDD.t3 sky130_fd_pr__pfet_01v8 ad=3.45 pd=11.38 as=2.05 ps=5.82 w=5 l=0.15
X5 Cin.t2 P.t10 Sum.t3 VDD.t7 sky130_fd_pr__pfet_01v8 ad=3.45 pd=11.38 as=2.05 ps=5.82 w=5 l=0.15
X6 P.t4 B.t4 A'.t2 error sky130_fd_pr__nfet_01v8 ad=0.82 pd=2.82 as=1.38 ps=5.38 w=2 l=0.15
X7 P.t3 B.t5 A.t0 VDD.t4 sky130_fd_pr__pfet_01v8 ad=2.05 pd=5.82 as=3.45 ps=11.38 w=5 l=0.15
X8 Sum.t2 Cin.t5 P.t1 VDD.t0 sky130_fd_pr__pfet_01v8 ad=2.05 pd=5.82 as=3.45 ps=11.38 w=5 l=0.15
X9 B.t2 P.t8 Cout.t1 VDD.t10 sky130_fd_pr__pfet_01v8 ad=3.45 pd=11.38 as=2.05 ps=5.82 w=5 l=0.15
X10 P'_X.t2 P.t11 VDD.t6 VDD.t5 sky130_fd_pr__pfet_01v8 ad=3.375 pd=11.35 as=3.375 ps=11.35 w=5 l=0.15
X11 P'_X.t1 P.t7 0 error sky130_fd_pr__nfet_01v8 ad=1.35 pd=5.35 as=1.35 ps=5.35 w=2 l=0.15
X12 Cout.t0 P'_M.t3 Cin.t3 VDD.t11 sky130_fd_pr__pfet_01v8 ad=2.05 pd=5.82 as=3.45 ps=11.38 w=5 l=0.15
X13 A'.t1 A.t1 0 error sky130_fd_pr__nfet_01v8 ad=1.35 pd=5.35 as=1.35 ps=5.35 w=2 l=0.15
X14 Cin.t0 P'_X.t3 Sum.t0 error sky130_fd_pr__nfet_01v8 ad=1.38 pd=5.38 as=0.82 ps=2.82 w=2 l=0.15
X15 P'_M.t1 P.t9 VDD.t9 VDD.t8 sky130_fd_pr__pfet_01v8 ad=3.375 pd=11.35 as=3.375 ps=11.35 w=5 l=0.15
X16 P'_M.t0 P.t6 0 error sky130_fd_pr__nfet_01v8 ad=1.35 pd=5.35 as=1.35 ps=5.35 w=2 l=0.15
X17 Sum.t1 Cin.t4 P'_X.t0 error sky130_fd_pr__nfet_01v8 ad=0.82 pd=2.82 as=1.38 ps=5.38 w=2 l=0.15
R0 Cout.n2 Cout.n0 89.0349
R1 Cout.n2 Cout.n1 65.9958
R2 Cout.n1 Cout.t2 24.6005
R3 Cout.n1 Cout.t3 24.6005
R4 Cout.n0 Cout.t1 16.1545
R5 Cout.n0 Cout.t0 16.1545
R6 Cout Cout.n2 11.3357
R7 P'_M.n0 P'_M.t3 1147
R8 P'_M.n0 P'_M.t2 615.926
R9 P'_M.n1 P'_M.t1 104.939
R10 P'_M.n1 P'_M.t0 90.8458
R11 P'_M P'_M.n2 5.96073
R12 P'_M.n2 P'_M.n1 4.5005
R13 P'_M.n2 P'_M.n0 0.691788
R14 Sum.n2 Sum.n0 88.5349
R15 Sum.n2 Sum.n1 66.4958
R16 Sum.n1 Sum.t0 24.6005
R17 Sum.n1 Sum.t1 24.6005
R18 Sum.n0 Sum.t3 16.1545
R19 Sum.n0 Sum.t2 16.1545
R20 Sum Sum.n2 8.83762
R21 P'_X.n0 P'_X.t3 616.856
R22 P'_X.n1 P'_X.t2 104.189
R23 P'_X.n0 P'_X.t0 96.0968
R24 P'_X.n1 P'_X.t1 91.5958
R25 P'_X.n2 P'_X.n1 4.5005
R26 P'_X P'_X.n2 3.46262
R27 P'_X.n2 P'_X.n0 0.511864
R28 Cin.n3 Cin.t5 1142
R29 Cin.n3 Cin.t4 611.557
R30 Cin.n1 Cin.t2 104.439
R31 Cin.n0 Cin.t3 104.439
R32 Cin.n0 Cin.t1 91.3458
R33 Cin.n1 Cin.t0 91.3458
R34 Cin.n2 Cin.n0 6.26565
R35 Cin.n2 Cin.n1 4.5005
R36 Cin.n4 Cin.n3 4.5005
R37 Cin Cin.n4 4.15391
R38 Cin.n4 Cin.n2 0.55353
R39 P.n0 P.t8 1146.73
R40 P.n3 P.t10 1146
R41 P.n1 P.t9 1139.89
R42 P.n5 P.t11 1139.89
R43 P.n0 P.t5 625.918
R44 P.n1 P.t6 612.057
R45 P.n5 P.t7 612.057
R46 P.n4 P.t1 108.439
R47 P.n9 P.n7 87.7849
R48 P.n9 P.n8 67.2458
R49 P.n8 P.t4 24.6005
R50 P.n8 P.t2 24.6005
R51 P.n7 P.t3 16.1545
R52 P.n7 P.t0 16.1545
R53 P.n10 P.n9 4.5005
R54 P.n6 P.n5 4.5005
R55 P.n2 P.n1 4.5005
R56 P P.n10 1.85845
R57 P.n10 P.n6 1.43989
R58 P.n3 P.n2 1.25618
R59 P.n6 P.n4 0.693682
R60 P.n4 P.n3 0.551636
R61 P.n2 P.n0 0.513758
R62 A'.n0 A'.t3 617.36
R63 A'.n1 A'.t0 103.689
R64 A'.n0 A'.t2 96.5968
R65 A'.n1 A'.t1 92.0958
R66 A'.n2 A'.n1 4.5005
R67 A' A'.n2 0.968303
R68 A'.n2 A'.n0 0.508076
R69 B.n3 B.t5 1141
R70 B.n3 B.t4 612.557
R71 B.n1 B.t0 103.439
R72 B.n0 B.t2 103.439
R73 B.n0 B.t3 92.3458
R74 B.n1 B.t1 92.3458
R75 B.n2 B.n0 9.5005
R76 B.n2 B.n1 4.5005
R77 B.n4 B.n3 4.5005
R78 B B.n4 1.65012
R79 B.n4 B.n2 0.55353
R80 A.n0 A.t2 1145.8
R81 A.n1 A.t3 1138.07
R82 A.n1 A.t1 612.807
R83 A.n0 A.t0 107.691
R84 A.n2 A.n1 4.5005
R85 A A.n2 0.790273
R86 A.n2 A.n0 0.693682
R87 VDD.t3 VDD.t5 383.354
R88 VDD.t7 VDD.t8 383.354
R89 VDD VDD.n2 380.18
R90 VDD.n3 VDD.n1 380.13
R91 VDD.n4 VDD.n0 380.13
R92 VDD.n2 VDD.t4 219.72
R93 VDD.n1 VDD.t0 219.72
R94 VDD.n0 VDD.t11 219.72
R95 VDD.t4 VDD.t3 112.174
R96 VDD.t0 VDD.t7 112.174
R97 VDD.t11 VDD.t10 112.174
R98 VDD.n5 VDD.t9 107.439
R99 VDD.n6 VDD.t6 107.439
R100 VDD.n7 VDD.t2 107.439
R101 VDD.n2 VDD.t1 47.992
R102 VDD.t5 VDD.n1 47.992
R103 VDD.t8 VDD.n0 47.992
R104 VDD.n5 VDD.n4 11.5247
R105 VDD.n7 VDD.n6 2.5005
R106 VDD.n6 VDD.n5 2.5005
R107 VDD.n4 VDD.n3 1.03175
R108 VDD.n3 VDD 0.982531
R109 VDD VDD.n7 0.610348
C0 P'_M P 1.11845f
C1 A P'_X 0.10429f
C2 P A' 1.74543f
C3 Sum P'_X 0.59071f
C4 P'_M A' 0.23968f
C5 A Cin 0.20051f
C6 Sum Cin 1.98605f
C7 Cout A 0.09607f
C8 Cout Sum 0.09272f
C9 B VDD 0.93341f
C10 B P'_X 0.20683f
C11 A P 0.78751f
C12 Sum P 0.79208f
C13 P'_M A 0.14728f
C14 P'_M Sum 0.9767f
C15 VDD P'_X 0.43788f
C16 Cin B 0.30302f
C17 A A' 0.93729f
C18 Cout B 0.58855f
C19 Sum A' 0.1885f
C20 Cin VDD 0.8181f
C21 Cout VDD 0.10302f
C22 Cin P'_X 1.73864f
C23 Cout P'_X 0.1951f
C24 P B 1.80049f
C25 P'_M B 0.4261f
C26 A' B 1.8149f
C27 Cout Cin 0.57391f
C28 P VDD 1.69452f
C29 P'_M VDD 0.68759f
C30 Sum A 0.09604f
C31 A' VDD 0.4389f
C32 P P'_X 1.96854f
C33 P'_M P'_X 0.23767f
C34 A' P'_X 0.19682f
C35 P Cin 1.47412f
C36 P'_M Cin 0.98768f
C37 Cout P 0.65128f
C38 P'_M Cout 1.61869f
C39 A' Cin 0.29296f
C40 A B 1.50489f
C41 Cout A' 0.18849f
C42 Sum B 0.19858f
C43 A VDD 1.74398f
C44 Sum VDD 0.09912f
C45 Cout 0 2.25508f
C46 P'_M 0 1.78101f
C47 Sum 0 1.56402f
C48 P'_X 0 1.6034f
C49 Cin 0 1.89055f
C50 P 0 2.79385f
C51 A' 0 1.41267f
C52 B 0 2.10862f
C53 A 0 1.22854f
C54 VDD 0 22.23332f
C55 VDD.t10 0 0.51948f
C56 VDD.t11 0 0.39235f
C57 VDD.n0 0 0.32244f
C58 VDD.t8 0 0.50991f
C59 VDD.t7 0 0.58579f
C60 VDD.t0 0 0.39235f
C61 VDD.n1 0 0.32244f
C62 VDD.t5 0 0.50991f
C63 VDD.t3 0 0.58579f
C64 VDD.t4 0 0.39235f
C65 VDD.t1 0 0.43951f
C66 VDD.n2 0 0.32245f
C67 VDD.n3 0 0.2085f
C68 VDD.n4 0 0.36095f
C69 VDD.t9 0 0.19888f
C70 VDD.n5 0 0.24693f
C71 VDD.t6 0 0.19888f
C72 VDD.n6 0 0.18718f
C73 VDD.t2 0 0.20137f
C74 VDD.n7 0 0.15978f
C75 A.t0 0 0.94437f
C76 A.n0 0 2.90438f
C77 A.n1 0 1.09115f
C78 A.n2 0 0.17009f
C79 B.t2 0 0.77304f
C80 B.t3 0 0.31328f
C81 B.n0 0 1.94723f
C82 B.t0 0 0.77453f
C83 B.t1 0 0.30823f
C84 B.n1 0 1.62752f
C85 B.n2 0 0.81067f
C86 B.n3 0 0.89625f
C87 B.n4 0 0.20742f
C88 A'.t2 0 0.35561f
C89 A'.n0 0 2.6485f
C90 A'.t0 0 0.81019f
C91 A'.t1 0 0.32311f
C92 A'.n1 0 1.73851f
C93 A'.n2 0 0.14881f
C94 P.n0 0 1.65979f
C95 P.n1 0 1.07096f
C96 P.n2 0 0.19902f
C97 P.n3 0 0.74455f
C98 P.t1 0 0.94798f
C99 P.n4 0 1.23951f
C100 P.n5 0 1.07096f
C101 P.n6 0 0.23993f
C102 P.t0 0 0.35941f
C103 P.t3 0 0.34153f
C104 P.n7 0 0.55757f
C105 P.t2 0 0.15352f
C106 P.t4 0 0.14785f
C107 P.n8 0 0.23547f
C108 P.n9 0 1.76879f
C109 P.n10 0 0.37098f
C110 Cin.t3 0 0.83889f
C111 Cin.t1 0 0.32703f
C112 Cin.n0 0 1.88469f
C113 Cin.t2 0 0.83493f
C114 Cin.t0 0 0.31832f
C115 Cin.n1 0 1.75092f
C116 Cin.n2 0 0.57615f
C117 Cin.n3 0 0.96562f
C118 Cin.n4 0 0.47731f
C119 P'_X.t0 0 0.34151f
C120 P'_X.n0 0 1.89691f
C121 P'_X.t2 0 0.79221f
C122 P'_X.t1 0 0.31024f
C123 P'_X.n1 0 1.68848f
C124 P'_X.n2 0 0.38945f
C125 Sum.t3 0 0.35335f
C126 Sum.t2 0 0.34334f
C127 Sum.n0 0 0.55778f
C128 Sum.t0 0 0.14978f
C129 Sum.t1 0 0.14896f
C130 Sum.n1 0 0.22439f
C131 Sum.n2 0 2.3638f
C132 P'_M.n0 0 1.50955f
C133 P'_M.t1 0 0.93301f
C134 P'_M.t0 0 0.35338f
C135 P'_M.n1 0 2.00172f
C136 P'_M.n2 0 0.77428f
C137 Cout.t1 0 0.30627f
C138 Cout.t0 0 0.30997f
C139 Cout.n0 0 0.46202f
C140 Cout.t2 0 0.13791f
C141 Cout.t3 0 0.13955f
C142 Cout.n1 0 0.18044f
C143 Cout.n2 0 1.9121f
.ends
