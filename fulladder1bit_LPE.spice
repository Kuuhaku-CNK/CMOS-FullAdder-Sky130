* NGSPICE file created from fulladder1bit.ext - technology: sky130A

.subckt fulladder1bit A B C CO S vdd gnd
X0 a_1095_400# a_195_1515.t4 a_3015_400# gnd.t5 sky130_fd_pr__nfet_01v8 ad=0.525 pd=2.05 as=0.525 ps=2.05 w=1 l=0.15
X1 S a_3015_400# gnd.t13 gnd.t12 sky130_fd_pr__nfet_01v8 ad=0.825 pd=3.65 as=0.525 ps=2.05 w=1 l=0.15
X2 a_1095_1800# C a_195_1515.t2 vdd sky130_fd_pr__pfet_01v8 ad=1.575 pd=4.05 as=1.575 ps=4.05 w=3 l=0.15
X3 a_1095_400# B gnd.t1 gnd.t7 sky130_fd_pr__nfet_01v8 ad=0.525 pd=2.05 as=0.525 ps=2.05 w=1 l=0.15
X4 vdd A a_660_1800.t0 vdd sky130_fd_pr__pfet_01v8 ad=1.575 pd=4.05 as=2.475 ps=7.65 w=3 l=0.15
X5 a_660_400# B gnd.t1 gnd.t8 sky130_fd_pr__nfet_01v8 ad=0.525 pd=2.05 as=0.525 ps=2.05 w=1 l=0.15
X6 a_2775_1800# B a_2535_1800# vdd sky130_fd_pr__pfet_01v8 ad=1.575 pd=4.05 as=1.575 ps=4.05 w=3 l=0.15
X7 vdd C a_660_1800.t4 vdd sky130_fd_pr__pfet_01v8 ad=1.575 pd=4.05 as=1.575 ps=4.05 w=3 l=0.15
X8 gnd.t1 B a_2055_400# gnd.t6 sky130_fd_pr__nfet_01v8 ad=0.525 pd=2.05 as=0.525 ps=2.05 w=1 l=0.15
X9 a_2775_400# B a_2535_400# gnd.t9 sky130_fd_pr__nfet_01v8 ad=0.525 pd=2.05 as=0.525 ps=2.05 w=1 l=0.15
X10 S a_3015_400# vdd vdd sky130_fd_pr__pfet_01v8 ad=2.475 pd=7.65 as=1.575 ps=4.05 w=3 l=0.15
X11 a_1095_1800# B vdd vdd sky130_fd_pr__pfet_01v8 ad=1.575 pd=4.05 as=1.575 ps=4.05 w=3 l=0.15
X12 CO a_195_1515.t5 gnd.t11 gnd.t10 sky130_fd_pr__nfet_01v8 ad=0.825 pd=3.65 as=0.825 ps=3.65 w=1 l=0.15
X13 gnd.t13 C a_1095_400# gnd.t16 sky130_fd_pr__nfet_01v8 ad=0.525 pd=2.05 as=0.525 ps=2.05 w=1 l=0.15
X14 a_1335_1800# A a_1095_1800# vdd sky130_fd_pr__pfet_01v8 ad=1.575 pd=4.05 as=1.575 ps=4.05 w=3 l=0.15
X15 vdd A a_1095_1800# vdd sky130_fd_pr__pfet_01v8 ad=1.575 pd=4.05 as=1.575 ps=4.05 w=3 l=0.15
X16 a_195_1515.t3 C a_660_400# gnd.t14 sky130_fd_pr__nfet_01v8 ad=0.525 pd=2.05 as=0.525 ps=2.05 w=1 l=0.15
X17 a_3015_400# C a_2775_1800# vdd sky130_fd_pr__pfet_01v8 ad=1.575 pd=4.05 as=1.575 ps=4.05 w=3 l=0.15
X18 CO a_195_1515.t7 vdd vdd sky130_fd_pr__pfet_01v8 ad=2.475 pd=7.65 as=2.475 ps=7.65 w=3 l=0.15
X19 gnd.t1 A a_660_400# gnd.t2 sky130_fd_pr__nfet_01v8 ad=0.525 pd=2.05 as=0.825 ps=3.65 w=1 l=0.15
X20 a_3015_400# C a_2775_400# gnd.t15 sky130_fd_pr__nfet_01v8 ad=0.525 pd=2.05 as=0.525 ps=2.05 w=1 l=0.15
X21 gnd.t1 A a_1095_400# gnd.t0 sky130_fd_pr__nfet_01v8 ad=0.525 pd=2.05 as=0.525 ps=2.05 w=1 l=0.15
X22 a_195_1515.t1 B a_1335_1800# vdd sky130_fd_pr__pfet_01v8 ad=1.575 pd=4.05 as=1.575 ps=4.05 w=3 l=0.15
X23 a_660_1800.t2 B vdd vdd sky130_fd_pr__pfet_01v8 ad=1.575 pd=4.05 as=1.575 ps=4.05 w=3 l=0.15
X24 a_2055_400# A a_195_1515.t0 gnd.t3 sky130_fd_pr__nfet_01v8 ad=0.525 pd=2.05 as=0.525 ps=2.05 w=1 l=0.15
X25 a_2535_1800# A a_660_1800.t1 vdd sky130_fd_pr__pfet_01v8 ad=1.575 pd=4.05 as=1.575 ps=4.05 w=3 l=0.15
X26 a_2535_400# A gnd.t1 gnd.t4 sky130_fd_pr__nfet_01v8 ad=0.525 pd=2.05 as=0.525 ps=2.05 w=1 l=0.15
X27 a_660_1800.t3 a_195_1515.t6 a_3015_400# vdd sky130_fd_pr__pfet_01v8 ad=1.575 pd=4.05 as=1.575 ps=4.05 w=3 l=0.15
R0 gnd.n3 gnd.n1 1970
R1 gnd.n8 gnd.n1 1576
R2 gnd.t2 gnd.t10 1565.84
R3 gnd.n5 gnd.n2 1379
R4 gnd.t10 gnd.n5 898.168
R5 gnd.n8 gnd.n0 236.928
R6 gnd.t0 gnd.t7 626.335
R7 gnd.t8 gnd.t14 626.335
R8 gnd.t14 gnd.t3 626.335
R9 gnd.t3 gnd.t6 626.335
R10 gnd.t4 gnd.t9 626.335
R11 gnd.t9 gnd.t15 626.335
R12 gnd.t15 gnd.t5 626.335
R13 gnd.t5 gnd.t16 626.335
R14 gnd.n3 gnd.t13 594.301
R15 gnd.n1 gnd.t1 594.301
R16 gnd.t1 gnd.n0 178.688
R17 gnd.n2 gnd.n0 236.928
R18 gnd.n5 gnd.t11 594.301
R19 gnd.t12 gnd.n3 585
R20 gnd.n4 gnd.n1 585
R21 gnd.n8 gnd.n7 585
R22 gnd.n6 gnd.n2 585
R23 gnd.n6 gnd.t2 313.168
R24 gnd.t7 gnd.n6 313.168
R25 gnd.n7 gnd.t0 313.168
R26 gnd.n7 gnd.t8 313.168
R27 gnd.t6 gnd.n4 313.168
R28 gnd.n4 gnd.t4 313.168
R29 gnd.t16 gnd.t12 313.168
R30 gnd.t13 gnd.t1 1.688
R31 gnd.t11 gnd.t1 1.03175
R32 gnd gnd.t1 0.0005
R33 a_660_1800.t0 a_660_1800.n2 636.37
R34 a_660_1800.n2 a_660_1800.n0 600.769
R35 a_660_1800.n2 a_660_1800.n1 599.269
R36 a_660_1800.n1 a_660_1800.t1 34.4755
R37 a_660_1800.n1 a_660_1800.t2 34.4755
R38 a_660_1800.n0 a_660_1800.t4 34.4755
R39 a_660_1800.n0 a_660_1800.t3 34.4755
R40 a_195_1515.n1 a_195_1515.t4 1654.87
R41 a_195_1515.n3 a_195_1515.t5 1654.87
R42 a_195_1515.n1 a_195_1515.t6 819.4
R43 a_195_1515.n3 a_195_1515.t7 819.4
R44 a_195_1515.t2 a_195_1515.n0 600.051
R45 a_195_1515.n0 a_195_1515.n2 200.05
R46 a_195_1515.n0 a_195_1515.n1 168.644
R47 a_195_1515.n0 a_195_1515.n3 168.457
R48 a_195_1515.n2 a_195_1515.t3 63.0005
R49 a_195_1515.n2 a_195_1515.t0 63.0005
R50 a_195_1515.t1 a_195_1515.t2 34.4755
C0 B vdd 0.52659f
C1 a_3015_400# a_660_400# 0
C2 CO A 0.13731f
C3 S C 0.02587f
C4 S a_1095_400# 0.01563f
C5 B a_660_400# 0.02807f
C6 S A 0
C7 vdd a_2055_400# 0
C8 a_3015_400# a_1095_1800# 0.00221f
C9 a_3015_400# a_2775_1800# 0.02901f
C10 A a_2535_1800# 0.00394f
C11 B a_1095_1800# 0.02228f
C12 B a_2775_1800# 0.00394f
C13 B a_1335_1800# 0.00394f
C14 a_3015_400# a_2535_400# 0.00632f
C15 vdd a_660_400# 0
C16 a_3015_400# a_2775_400# 0.01561f
C17 a_3015_400# C 0.47533f
C18 B a_2535_400# 0
C19 a_3015_400# a_1095_400# 0.16355f
C20 B a_2775_400# 0
C21 C B 1.14054f
C22 B a_1095_400# 0.06966f
C23 A a_3015_400# 0.00943f
C24 vdd a_1095_1800# 0.1969f
C25 vdd a_2775_1800# 0.01688f
C26 A B 1.68641f
C27 vdd a_1335_1800# 0.02157f
C28 a_1095_400# a_2055_400# 0.00878f
C29 C vdd 0.38855f
C30 vdd a_1095_400# 0.00127f
C31 A a_2055_400# 0.00104f
C32 a_1095_1800# a_2775_1800# 0
C33 CO B 0.07747f
C34 C a_660_400# 0.01109f
C35 S a_3015_400# 0.15043f
C36 a_660_400# a_1095_400# 0.25917f
C37 A vdd 0.53596f
C38 a_1095_1800# a_1335_1800# 0.05828f
C39 a_3015_400# a_2535_1800# 0.01254f
C40 S B 0
C41 A a_660_400# 0.0855f
C42 B a_2535_1800# 0.00394f
C43 C a_1095_1800# 0.01856f
C44 a_1095_1800# a_1095_400# 0.00311f
C45 C a_2775_1800# 0.00394f
C46 CO vdd 0.18967f
C47 A a_1095_1800# 0.03038f
C48 CO a_660_400# 0.02246f
C49 S vdd 0.15466f
C50 a_2535_400# a_1095_400# 0.00878f
C51 A a_1335_1800# 0.00394f
C52 C a_2775_400# 0
C53 vdd a_2535_1800# 0.01688f
C54 a_2775_400# a_1095_400# 0.00878f
C55 C a_1095_400# 0.0762f
C56 a_3015_400# B 0.01995f
C57 A a_2535_400# 0.00104f
C58 CO a_1095_1800# 0.00398f
C59 A C 0.38133f
C60 A a_1095_400# 0.3771f
C61 CO a_1335_1800# 0.00192f
C62 a_3015_400# a_2055_400# 0
C63 B a_2055_400# 0
C64 a_2535_1800# a_1095_1800# 0.00148f
C65 a_3015_400# vdd 0.24035f
C66 CO C 0.09313f
C67 CO a_1095_400# 0.00342f
C68 S gnd 1.25585f
C69 CO gnd 0.65563f
C70 vdd gnd 18.3452f
C71 a_2775_400# gnd 0.01642f
C72 a_2535_400# gnd 0.02532f
C73 a_2055_400# gnd 0.02571f
C74 a_1095_400# gnd 2.30457f
C75 a_660_400# gnd 0.47414f
C76 a_1335_1800# gnd 0
C77 a_1095_1800# gnd 1.22988f
C78 a_3015_400# gnd 0.05069f
C79 a_195_1515.n0 gnd 2.36295f
C80 a_195_1515.n1 gnd 0.16786f
C81 a_195_1515.t0 gnd 0.05403f
C82 a_195_1515.t3 gnd 0.05403f
C83 a_195_1515.n2 gnd 0.11982f
C84 a_195_1515.n3 gnd 0.16869f
C85 a_195_1515.t2 gnd 1.67981f
C86 a_195_1515.t1 gnd 0.16209f
C87 a_660_1800.t4 gnd 0.07848f
C88 a_660_1800.t3 gnd 0.12917f
C89 a_660_1800.n0 gnd 0.15842f
C90 a_660_1800.t1 gnd 0.07848f
C91 a_660_1800.t2 gnd 0.07848f
C92 a_660_1800.n1 gnd 0.15793f
C93 a_660_1800.n2 gnd 0.82181f
C94 a_660_1800.t0 gnd 1.96826f
C95 gnd.t1 gnd 1.57027f
C96 gnd.t13 gnd 0.61831f
C97 gnd.t11 gnd 0.05526f
.ends
